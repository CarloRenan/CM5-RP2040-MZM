Canal I: curva estatica por patamares de DAC
* Curva amostrada apos 100 ms de acomodacao inicial.
* Projeto CM5 R6, 15 V, conector de duas vias.
* DAC substituido por fonte analogica ideal; contato de rele funcional; carga externa de 10 kohm. Curva estatica amostrada aos 90% de cada patamar de 25 ms; nao e uma analise .dc.
.include "../modelos/OPA380_TI.lib"
.include "../modelos/OPAx197_TI.lib"
.include "../modelos/funcionais.lib"
.options reltol=1e-5 abstol=1e-12 vntol=1e-6 itl1=300 method=gear
.temp 27
V5 AVDD5 0 5
V33 MCU_3V3 0 3.3
VP P11 0 11
VN N11 0 -11
VSYS V5SYS 0 5.0714932127
VREFA REF_ADC_RAW 0 2.5
R400 REF_ADC_RAW REF_ADC 1u
C400 REF_ADC 0 1u
C401 REF_ADC 0 100n
VREFD REF_DAC 0 2.5
R602 REF_DAC MID_DIV 10.0k
R603 MID_DIV 0 10.0k
C604 MID_DIV 0 1u
C605 AVDD5 0 100n
XU601 MID_DIV VMID_DAC AVDD5 0 VMID_DAC OPAx197
XU1100 REF_ADC REF_BUF AVDD5 0 REF_BUF OPAx197
C700 BIAS_F_I 0 1u
C701 P11 0 100n
C702 N11 0 100n
R700 VMID_DAC INV_I 10.0k
R701 DRV_I INV_I 63.4k
R702 DAC_I NONINV_I 10.0k
R703 NONINV_I 0 63.4k
R704 DRV_I BIAS_F_I 220
R705 SAFE_R_I 0 1k
R706 BIAS_OUT_I 0 1Meg
XU700 NONINV_I INV_I P11 N11 DRV_I OPAx197
SK700NO BIAS_F_I BIAS_OUT_I ENABLE 0 CONTATO
BK700NC CTL_NC_I 0 V={3.3-V(ENABLE)}
SK700NC SAFE_R_I BIAS_OUT_I CTL_NC_I 0 CONTATO
RLOAD_I BIAS_OUT_I 0 10k
R1110 BIAS_F_I MON_I 80.6k
R1111 REF_BUF MON_I 20.0k
R1112 MON_I 0 26.7k
C1110 MON_I 0 1n
VDAC DAC_I 0 PWL(0 0 0.1 0 0.12499 0 0.125 0.05 0.14999 0.05 0.15 0.1 0.17499 0.1 0.175 0.15 0.19999 0.15 0.2 0.2 0.22499 0.2 0.225 0.25 0.24999 0.25 0.25 0.3 0.27499 0.3 0.275 0.35 0.29999 0.35 0.3 0.4 0.32499 0.4 0.325 0.45 0.34999 0.45 0.35 0.5 0.37499 0.5 0.375 0.55 0.39999 0.55 0.4 0.6 0.42499 0.6 0.425 0.65 0.44999 0.65 0.45 0.7 0.47499 0.7 0.475 0.75 0.49999 0.75 0.5 0.8 0.52499 0.8 0.525 0.85 0.54999 0.85 0.55 0.9 0.57499 0.9 0.575 0.95 0.59999 0.95 0.6 1 0.62499 1 0.625 1.05 0.64999 1.05 0.65 1.1 0.67499 1.1 0.675 1.15 0.69999 1.15 0.7 1.2 0.72499 1.2 0.725 1.25 0.74999 1.25 0.75 1.3 0.77499 1.3 0.775 1.35 0.79999 1.35 0.8 1.4 0.82499 1.4 0.825 1.45 0.84999 1.45 0.85 1.5 0.87499 1.5 0.875 1.55 0.89999 1.55 0.9 1.6 0.92499 1.6 0.925 1.65 0.94999 1.65 0.95 1.7 0.97499 1.7 0.975 1.75 0.99999 1.75 1 1.8 1.02499 1.8 1.025 1.85 1.04999 1.85 1.05 1.9 1.07499 1.9 1.075 1.95 1.09999 1.95 1.1 2 1.12499 2 1.125 2.05 1.14999 2.05 1.15 2.1 1.17499 2.1 1.175 2.15 1.19999 2.15 1.2 2.2 1.22499 2.2 1.225 2.25 1.24999 2.25 1.25 2.3 1.27499 2.3 1.275 2.35 1.29999 2.35 1.3 2.4 1.32499 2.4 1.325 2.45 1.34999 2.45 1.35 2.5 1.37499 2.5 1.375 2.5)
VEN ENABLE 0 3.3
.tran 100u 1.375 0 100u

.end
