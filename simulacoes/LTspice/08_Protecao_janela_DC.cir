Comparadores: janela de BIAS dos tres canais
* Projeto CM5 R6, 15 V, conector de duas vias.
* LM339B representado por comparador ideal com coletor aberto; offset, atraso e histerese nao modelados.
.include "../modelos/OPA380_TI.lib"
.include "../modelos/OPAx197_TI.lib"
.include "../modelos/funcionais.lib"
.options reltol=1e-5 abstol=1e-12 vntol=1e-6 itl1=300 method=gear
.temp 27
* U1100 ideal neste teste logico; rede resistiva preservada.
V5 AVDD5 0 5
V33 MCU_3V3 0 3.3
VP P11 0 11
VN N11 0 -11
VSYS V5SYS 0 5.0714932127
VREFA REF_ADC_RAW 0 2.5
R400 REF_ADC_RAW REF_ADC 1u
C400 REF_ADC 0 1u
C401 REF_ADC 0 100n
VREFD REF_DAC 0 2.5
C1100 AVDD5 0 100n
C1110 MON_I 0 1n
C1111 MON_Q 0 1n
C1112 MON_PHI 0 1n
R1100 REF_BUF VHI 11.0k
R1101 VHI VLO 78.7k
R1102 VLO 0 11.0k
R1103 REF_BUF VRAIL 10.0k
R1104 VRAIL 0 15.0k
R1110 BIAS_F_I MON_I 80.6k
R1111 REF_BUF MON_I 20.0k
R1112 MON_I 0 26.7k
R1114 BIAS_F_Q MON_Q 80.6k
R1115 REF_BUF MON_Q 20.0k
R1116 MON_Q 0 26.7k
R1118 BIAS_F_PHI MON_PHI 80.6k
R1119 REF_BUF MON_PHI 20.0k
R1120 MON_PHI 0 26.7k
E_REFBUF REF_BUF 0 REF_ADC 0 1
R1004 MCU_3V3 FAULT_N 10k
R1006 P11 RAIL_POS 56.0k
R1007 RAIL_POS 0 10.0k
R1008 N11 RAIL_NEG 113k
R1009 REF_BUF RAIL_NEG 10.0k
XU1101_1 VHI MON_I FAULT_N 0 CMP_OC
XU1101_2 MON_I VLO FAULT_N 0 CMP_OC
XU1101_3 VHI MON_Q FAULT_N 0 CMP_OC
XU1101_4 MON_Q VLO FAULT_N 0 CMP_OC
XU1102_1 VHI MON_PHI FAULT_N 0 CMP_OC
XU1102_2 MON_PHI VLO FAULT_N 0 CMP_OC
XU1102_3 RAIL_POS VRAIL FAULT_N 0 CMP_OC
XU1102_4 VRAIL RAIL_NEG FAULT_N 0 CMP_OC
VBI BIAS_F_I 0 0
VBQ BIAS_F_Q 0 0
VBP BIAS_F_PHI 0 0
.dc VBI -9 9 0.005

.end
