MZM ideal: cadeia funcional BIAS-potencia-fotocorrente-TIA
* Curva amostrada apos 100 ms de acomodacao inicial.
* Projeto CM5 R6, 15 V, conector de duas vias.
* MZM hipotetico: Vpi=4 V, Pin=1 mW, tap=1%, responsividade=0.8 A/W. Nao identifica o MZM UFCG nem simula controle fechado. Curva por patamares de 25 ms; amostragem aos 90% do patamar.
.include "../modelos/OPA380_TI.lib"
.include "../modelos/OPAx197_TI.lib"
.include "../modelos/funcionais.lib"
.options reltol=1e-5 abstol=1e-12 vntol=1e-6 itl1=300 method=gear
.temp 27
.subckt OP_FUNC P M VP VN OUT
EGAIN OUT 0 P M 1e6
.ends OP_FUNC
* Cadeia funcional: opamps ideais de ganho 1e6, sem saturacao ou ruido.
* Macromodelos TI sao avaliados separadamente nos ensaios 01 a 07, 10 e 11.
V5 AVDD5 0 5
V33 MCU_3V3 0 3.3
VP P11 0 11
VN N11 0 -11
VSYS V5SYS 0 5.0714932127
VREFA REF_ADC_RAW 0 2.5
R400 REF_ADC_RAW REF_ADC 1u
C400 REF_ADC 0 1u
C401 REF_ADC 0 100n
VREFD REF_DAC 0 2.5
R602 REF_DAC MID_DIV 10.0k
R603 MID_DIV 0 10.0k
C604 MID_DIV 0 1u
C605 AVDD5 0 100n
XU601 MID_DIV VMID_DAC AVDD5 0 VMID_DAC OP_FUNC
XU1100 REF_ADC REF_BUF AVDD5 0 REF_BUF OP_FUNC
C700 BIAS_F_I 0 1u
C701 P11 0 100n
C702 N11 0 100n
R700 VMID_DAC INV_I 10.0k
R701 DRV_I INV_I 63.4k
R702 DAC_I NONINV_I 10.0k
R703 NONINV_I 0 63.4k
R704 DRV_I BIAS_F_I 220
R705 SAFE_R_I 0 1k
R706 BIAS_OUT_I 0 1Meg
XU700 NONINV_I INV_I P11 N11 DRV_I OP_FUNC
SK700NO BIAS_F_I BIAS_OUT_I ENABLE 0 CONTATO
BK700NC CTL_NC_I 0 V={3.3-V(ENABLE)}
SK700NC SAFE_R_I BIAS_OUT_I CTL_NC_I 0 CONTATO
RLOAD_I BIAS_OUT_I 0 1e12
R1110 BIAS_F_I MON_I 80.6k
R1111 REF_BUF MON_I 20.0k
R1112 MON_I 0 26.7k
C1110 MON_I 0 1n
C500 PD_K TIA_OUT 100p
C501 AVDD5 0 100n
C502 VDARK_DIV 0 1u
C503 AVDD5 0 100n
C504 SK_A SK_OUT 100n
C505 SK_B 0 47n
C506 AVDD5 0 100n
C507 PHOTO_ADC 0 10n
R500 PD_K TIA_OUT 220k
R501 REF_ADC VDARK_DIV 90.9k
R502 VDARK_DIV 0 10.0k
R503 TIA_OUT SK_A 10.0k
R504 SK_A SK_B 10.0k
R505 SK_OUT PHOTO_ADC 100
R506 PD_RAW PD_K 10k
XU500 VDARK PD_K AVDD5 0 TIA_OUT OP_FUNC
XU501 VDARK_DIV VDARK AVDD5 0 VDARK OP_FUNC
XU502 SK_B SK_OUT AVDD5 0 SK_OUT OP_FUNC
VEN ENABLE 0 3.3
VDAC DAC_I 0 PWL(0 0.5 0.1 0.5 0.12499 0.5 0.125 0.525 0.14999 0.525 0.15 0.55 0.17499 0.55 0.175 0.575 0.19999 0.575 0.2 0.6 0.22499 0.6 0.225 0.625 0.24999 0.625 0.25 0.65 0.27499 0.65 0.275 0.675 0.29999 0.675 0.3 0.7 0.32499 0.7 0.325 0.725 0.34999 0.725 0.35 0.75 0.37499 0.75 0.375 0.775 0.39999 0.775 0.4 0.8 0.42499 0.8 0.425 0.825 0.44999 0.825 0.45 0.85 0.47499 0.85 0.475 0.875 0.49999 0.875 0.5 0.9 0.52499 0.9 0.525 0.925 0.54999 0.925 0.55 0.95 0.57499 0.95 0.575 0.975 0.59999 0.975 0.6 1 0.62499 1 0.625 1.025 0.64999 1.025 0.65 1.05 0.67499 1.05 0.675 1.075 0.69999 1.075 0.7 1.1 0.72499 1.1 0.725 1.125 0.74999 1.125 0.75 1.15 0.77499 1.15 0.775 1.175 0.79999 1.175 0.8 1.2 0.82499 1.2 0.825 1.225 0.84999 1.225 0.85 1.25 0.87499 1.25 0.875 1.275 0.89999 1.275 0.9 1.3 0.92499 1.3 0.925 1.325 0.94999 1.325 0.95 1.35 0.97499 1.35 0.975 1.375 0.99999 1.375 1 1.4 1.02499 1.4 1.025 1.425 1.04999 1.425 1.05 1.45 1.07499 1.45 1.075 1.475 1.09999 1.475 1.1 1.5 1.12499 1.5 1.125 1.525 1.14999 1.525 1.15 1.55 1.17499 1.55 1.175 1.575 1.19999 1.575 1.2 1.6 1.22499 1.6 1.225 1.625 1.24999 1.625 1.25 1.65 1.27499 1.65 1.275 1.675 1.29999 1.675 1.3 1.7 1.32499 1.7 1.325 1.725 1.34999 1.725 1.35 1.75 1.37499 1.75 1.375 1.775 1.39999 1.775 1.4 1.8 1.42499 1.8 1.425 1.825 1.44999 1.825 1.45 1.85 1.47499 1.85 1.475 1.875 1.49999 1.875 1.5 1.9 1.52499 1.9 1.525 1.925 1.54999 1.925 1.55 1.95 1.57499 1.95 1.575 1.975 1.59999 1.975 1.6 2 1.62499 2 1.625 2)
.param VPI=4 PIN_OPT=1m TAP=0.01 RESPONS=0.8 PHI0=0
BOPT POTENCIA_OPTICA 0 V={PIN_OPT*0.5*(1+cos(3.141592653589793*V(BIAS_OUT_I)/VPI+PHI0))}
BPD PD_RAW 0 I={RESPONS*TAP*V(POTENCIA_OPTICA)}
.tran 100u 1.625 0 100u

.end
