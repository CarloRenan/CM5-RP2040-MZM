TIA: curva estatica por patamares de corrente
* Curva amostrada apos 100 ms de acomodacao inicial.
* Projeto CM5 R6, 15 V, conector de duas vias.
* Fotodiodo representado por corrente ideal; capacidade, fuga e tensao real do detector nao identificadas. Curva estatica amostrada aos 90% de cada patamar de 25 ms; nao e uma analise .dc.
.include "../modelos/OPA380_TI.lib"
.include "../modelos/OPAx197_TI.lib"
.include "../modelos/funcionais.lib"
.options reltol=1e-5 abstol=1e-12 vntol=1e-6 itl1=300 method=gear
.temp 27
V5 AVDD5 0 5
V33 MCU_3V3 0 3.3
VP P11 0 11
VN N11 0 -11
VSYS V5SYS 0 5.0714932127
VREFA REF_ADC_RAW 0 2.5
R400 REF_ADC_RAW REF_ADC 1u
C400 REF_ADC 0 1u
C401 REF_ADC 0 100n
VREFD REF_DAC 0 2.5
C500 PD_K TIA_OUT 100p
C501 AVDD5 0 100n
C502 VDARK_DIV 0 1u
C503 AVDD5 0 100n
C504 SK_A SK_OUT 100n
C505 SK_B 0 47n
C506 AVDD5 0 100n
C507 PHOTO_ADC 0 10n
R500 PD_K TIA_OUT 220k
R501 REF_ADC VDARK_DIV 90.9k
R502 VDARK_DIV 0 10.0k
R503 TIA_OUT SK_A 10.0k
R504 SK_A SK_B 10.0k
R505 SK_OUT PHOTO_ADC 100
R506 PD_RAW PD_K 10k
XU500 VDARK PD_K AVDD5 0 TIA_OUT OPA380
XU501 VDARK_DIV VDARK AVDD5 0 VDARK OPAx197
XU502 SK_B SK_OUT AVDD5 0 SK_OUT OPAx197
IPD PD_RAW 0 PWL(0 0 0.1 0 0.12499 0 0.125 1e-06 0.14999 1e-06 0.15 2e-06 0.17499 2e-06 0.175 3e-06 0.19999 3e-06 0.2 4e-06 0.22499 4e-06 0.225 5e-06 0.24999 5e-06 0.25 6e-06 0.27499 6e-06 0.275 7e-06 0.29999 7e-06 0.3 8e-06 0.32499 8e-06 0.325 9e-06 0.34999 9e-06 0.35 1e-05 0.37499 1e-05 0.375 1.1e-05 0.39999 1.1e-05 0.4 1.2e-05 0.42499 1.2e-05 0.425 1.3e-05 0.44999 1.3e-05 0.45 1.4e-05 0.47499 1.4e-05 0.475 1.5e-05 0.49999 1.5e-05 0.5 1.6e-05 0.52499 1.6e-05 0.525 1.7e-05 0.54999 1.7e-05 0.55 1.8e-05 0.57499 1.8e-05 0.575 1.9e-05 0.59999 1.9e-05 0.6 2e-05 0.62499 2e-05 0.625 2e-05)
.tran 100u 0.625 0 100u

.end
