Watchdog: perda de bordas com heartbeat travado alto
* Projeto CM5 R6, 15 V, conector de duas vias.
* Modelo funcional do HCT123 e porta AND. Nao executa firmware nem valida tolerancia de temporizacao. Transicoes suavizadas apenas para convergencia; nao sao atrasos de datasheet.
.include "../modelos/OPA380_TI.lib"
.include "../modelos/OPAx197_TI.lib"
.include "../modelos/funcionais.lib"
.options reltol=1e-5 abstol=1e-12 vntol=1e-6 itl1=300 method=gear
.temp 27
V5 AVDD5 0 5
V33 MCU_3V3 0 3.3
VP P11 0 11
VN N11 0 -11
VSYS V5SYS 0 5.0714932127
VREFA REF_ADC_RAW 0 2.5
R400 REF_ADC_RAW REF_ADC 1u
C400 REF_ADC 0 1u
C401 REF_ADC 0 100n
VREFD REF_DAC 0 2.5
R602 REF_DAC MID_DIV 10.0k
R603 MID_DIV 0 10.0k
C604 MID_DIV 0 1u
C605 AVDD5 0 100n
XU601 MID_DIV VMID_DAC AVDD5 0 VMID_DAC OPAx197
XU1100 REF_ADC REF_BUF AVDD5 0 REF_BUF OPAx197
C700 BIAS_F_I 0 1u
C701 P11 0 100n
C702 N11 0 100n
R700 VMID_DAC INV_I 10.0k
R701 DRV_I INV_I 63.4k
R702 DAC_I NONINV_I 10.0k
R703 NONINV_I 0 63.4k
R704 DRV_I BIAS_F_I 220
R705 SAFE_R_I 0 1k
R706 BIAS_OUT_I 0 1Meg
XU700 NONINV_I INV_I P11 N11 DRV_I OPAx197
SK700NO BIAS_F_I BIAS_OUT_I ENABLE 0 CONTATO
BK700NC CTL_NC_I 0 V={3.3-V(ENABLE)}
SK700NC SAFE_R_I BIAS_OUT_I CTL_NC_I 0 CONTATO
RLOAD_I BIAS_OUT_I 0 10k
R1110 BIAS_F_I MON_I 80.6k
R1111 REF_BUF MON_I 20.0k
R1112 MON_I 0 26.7k
C1110 MON_I 0 1n
VHBM MCU_HEARTBEAT 0 PULSE(0 3.3 100m 1u 1u 10m 100m)
VHBC CM5_HEARTBEAT 0 PWL(0 0 100m 0 100.001m 3.3 110m 3.3 110.001m 0 200m 0 200.001m 3.3 210m 3.3 210.001m 0 300m 0 300.001m 3.3 310m 3.3 310.001m 0 400m 0 400.001m 3.3 410m 3.3 410.001m 0 500m 0 500.001m 3.3)
VARM MCU_ARM 0 PWL(0 0 50m 0 50.001m 3.3)
XWD_MCU MCU_HEARTBEAT MCU_ARM WD_MCU 0 MONO_FUNC
XWD_CM5 CM5_HEARTBEAT MCU_ARM WD_CM5 0 MONO_FUNC
VFAULT FAULT_N 0 3.3
BEN ENABLE 0 V={3.3*(1+tanh((V(WD_MCU)-2)/0.02))*(1+tanh((V(WD_CM5)-2)/0.02))*(1+tanh((V(FAULT_N)-2)/0.02))/8}
VDAC DAC_I 0 0.855678233438
.tran 100u 1.2 0 100u

.end
