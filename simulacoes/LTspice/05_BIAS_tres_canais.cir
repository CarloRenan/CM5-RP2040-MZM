Tres canais: I, Q e PHI com pequeno tom
* Projeto CM5 R6, 15 V, conector de duas vias.
* DAC e contato funcionais; os valores de comando nao sao limites autorizados para o MZM fisico.
.include "../modelos/OPA380_TI.lib"
.include "../modelos/OPAx197_TI.lib"
.include "../modelos/funcionais.lib"
.options reltol=1e-5 abstol=1e-12 vntol=1e-6 itl1=300 method=gear
.temp 27
V5 AVDD5 0 5
V33 MCU_3V3 0 3.3
VP P11 0 11
VN N11 0 -11
VSYS V5SYS 0 5.0714932127
VREFA REF_ADC_RAW 0 2.5
R400 REF_ADC_RAW REF_ADC 1u
C400 REF_ADC 0 1u
C401 REF_ADC 0 100n
VREFD REF_DAC 0 2.5
R602 REF_DAC MID_DIV 10.0k
R603 MID_DIV 0 10.0k
C604 MID_DIV 0 1u
C605 AVDD5 0 100n
XU601 MID_DIV VMID_DAC AVDD5 0 VMID_DAC OPAx197
XU1100 REF_ADC REF_BUF AVDD5 0 REF_BUF OPAx197
VEN ENABLE 0 3.3
C700 BIAS_F_I 0 1u
C701 P11 0 100n
C702 N11 0 100n
R700 VMID_DAC INV_I 10.0k
R701 DRV_I INV_I 63.4k
R702 DAC_I NONINV_I 10.0k
R703 NONINV_I 0 63.4k
R704 DRV_I BIAS_F_I 220
R705 SAFE_R_I 0 1k
R706 BIAS_OUT_I 0 1Meg
XU700 NONINV_I INV_I P11 N11 DRV_I OPAx197
SK700NO BIAS_F_I BIAS_OUT_I ENABLE 0 CONTATO
BK700NC CTL_NC_I 0 V={3.3-V(ENABLE)}
SK700NC SAFE_R_I BIAS_OUT_I CTL_NC_I 0 CONTATO
RLOAD_I BIAS_OUT_I 0 10k
R1110 BIAS_F_I MON_I 80.6k
R1111 REF_BUF MON_I 20.0k
R1112 MON_I 0 26.7k
C1110 MON_I 0 1n
VDAC_I DAC_I 0 SINE(0.855678233438 0.00315457413249 17)
C800 BIAS_F_Q 0 1u
C801 P11 0 100n
C802 N11 0 100n
R800 VMID_DAC INV_Q 10.0k
R801 DRV_Q INV_Q 63.4k
R802 DAC_Q NONINV_Q 10.0k
R803 NONINV_Q 0 63.4k
R804 DRV_Q BIAS_F_Q 220
R805 SAFE_R_Q 0 1k
R806 BIAS_OUT_Q 0 1Meg
XU800 NONINV_Q INV_Q P11 N11 DRV_Q OPAx197
SK800NO BIAS_F_Q BIAS_OUT_Q ENABLE 0 CONTATO
BK800NC CTL_NC_Q 0 V={3.3-V(ENABLE)}
SK800NC SAFE_R_Q BIAS_OUT_Q CTL_NC_Q 0 CONTATO
RLOAD_Q BIAS_OUT_Q 0 10k
R1114 BIAS_F_Q MON_Q 80.6k
R1115 REF_BUF MON_Q 20.0k
R1116 MON_Q 0 26.7k
C1111 MON_Q 0 1n
VDAC_Q DAC_Q 0 SINE(1.25 0.00315457413249 17)
C900 BIAS_F_PHI 0 1u
C901 P11 0 100n
C902 N11 0 100n
R900 VMID_DAC INV_PHI 10.0k
R901 DRV_PHI INV_PHI 63.4k
R902 DAC_PHI NONINV_PHI 10.0k
R903 NONINV_PHI 0 63.4k
R904 DRV_PHI BIAS_F_PHI 220
R905 SAFE_R_PHI 0 1k
R906 BIAS_OUT_PHI 0 1Meg
XU900 NONINV_PHI INV_PHI P11 N11 DRV_PHI OPAx197
SK900NO BIAS_F_PHI BIAS_OUT_PHI ENABLE 0 CONTATO
BK900NC CTL_NC_PHI 0 V={3.3-V(ENABLE)}
SK900NC SAFE_R_PHI BIAS_OUT_PHI CTL_NC_PHI 0 CONTATO
RLOAD_PHI BIAS_OUT_PHI 0 10k
R1118 BIAS_F_PHI MON_PHI 80.6k
R1119 REF_BUF MON_PHI 20.0k
R1120 MON_PHI 0 26.7k
C1112 MON_PHI 0 1n
VDAC_PHI DAC_PHI 0 SINE(1.64432176656 0.00315457413249 17)
.tran 100u 300m 0 100u

.end
